* Generic reference/package model; NOT a characterized SKY130 ADC/reference
VREF ideal 0 1.8
RSRC ideal n1 5
LPKG n1 ref 1n
RESR ref cap .2
CDEC cap 0 20p
IPULSE ref 0 PULSE(0 .5m 10n .2n .2n 2n 100n)
.options reltol=1e-6 abstol=1e-14
.control
set wr_vecnames
set wr_singlescale
set numdgt=12
tran 5p 80n 0 5p
wrdata tran.dat v(ref) v(cap) i(VREF)
quit
.endc
.end
