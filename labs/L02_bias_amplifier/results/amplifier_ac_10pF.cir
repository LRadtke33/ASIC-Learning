* L02: NMOS common-source amplifier with a PMOS mirror load.
* Explicit body ties. VNSENSE and VPSENSE are ideal zero-volt current probes.
* Device geometry is supported by the selected model bins. Diffusion geometry is assumed.
.lib "../../common/models/sky130_course.lib.spice" tt
.temp 25
.options reltol=1e-6 abstol=1e-12 vntol=1e-9
VDD vdd 0 1.8
IREF vbiasp 0 20u
XMPREF vbiasp vbiasp vdd vdd sky130_fd_pr__pfet_01v8_hvt w=7 l=1 ad=2.03 as=2.03 pd=14.58 ps=14.58
XMP pdrain vbiasp vdd vdd sky130_fd_pr__pfet_01v8_hvt w=7 l=1 ad=2.03 as=2.03 pd=14.58 ps=14.58
VPSENSE pdrain out 0
VNSENSE out ndrain 0
XMN ndrain vin 0 0 sky130_fd_pr__nfet_01v8 w=5 l=1 ad=1.45 as=1.45 pd=10.58 ps=10.58
VSIG vin 0 DC 0.757010793686 AC 1
CLOAD out 0 10p

.control
set wr_vecnames
set wr_singlescale
set numdgt=15
ac dec 80 10 100meg
let gain_real=real(v(out))
let gain_imag=imag(v(out))
wrdata amplifier_ac_10pF.dat gain_real gain_imag
quit
.endc
.end
