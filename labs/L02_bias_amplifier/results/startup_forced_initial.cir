* L02: BEHAVIORAL STARTUP MODEL ONLY. Not a transistor circuit or a SKY130 bandgap.
* x is a normalized bias-state represented by volts; stable states are x=0 and x=1.
* C*dx/dt = C/tau * x*(x-0.3)*(1-x), gated by supply availability.
* C=1nF, tau=50us. Kick=5uA below x~0.6, so it turns off after successful startup.
* Ramps, initial conditions, and restart behavior are deliberate test variables.
.temp 25
.options reltol=1e-6 abstol=1e-12 vntol=1e-9 method=gear
VDD vdd 0 DC 1.8
BACTIVE active 0 V={0.5*(1+tanh((v(vdd)-0.8)/0.05))}
CSTATE x 0 1n ic=0.8
BCORE 0 x I={20u*v(active)*v(x)*(v(x)-0.3)*(1-v(x))}
BOFF x 0 I={20u*(1-v(active))*v(x)}
BKICK 0 kicknode I={5u*v(active)*0.5*(1-tanh((v(x)-0.6)/0.02))*(0)}
VKICK kicknode x 0
BREF ref 0 V={min(max(1.2*v(x),0),v(vdd))}
RLOAD ref 0 1meg
.control
set wr_vecnames
set wr_singlescale
set numdgt=15
tran 1u 5m 0 2u uic
let supply=v(vdd)
let state=v(x)
let reference=v(ref)
let kick_current=i(vkick)
wrdata startup_forced_initial.dat supply state reference kick_current
quit
.endc
.end
