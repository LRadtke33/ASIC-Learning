* Educational geometry-derived RC ESTIMATE, not foundry extraction.
* Coefficients and omitted mechanisms: ../../sky130_coefficients.json
.subckt ROUTE SIG_DRV SIG_RX AGG REF
Rseg000 SIG_DRV SIG_001 2.35
Rseg001 SIG_001 SIG_002 2.35
Rseg002 SIG_002 SIG_003 2.35
Rseg003 SIG_003 SIG_004 2.35
Rseg004 SIG_004 SIG_005 2.35
Rseg005 SIG_005 SIG_006 2.35
Rseg006 SIG_006 SIG_007 2.35
Rseg007 SIG_007 SIG_008 2.35
Rseg008 SIG_008 SIG_009 2.35
Rseg009 SIG_009 SIG_RX 2.35
Cg000 SIG_DRV REF 1.769602800000e-15
Cg001 SIG_001 REF 3.483328800000e-15
Cg002 SIG_002 REF 3.483328800000e-15
Cg003 SIG_003 REF 3.483328800000e-15
Cg004 SIG_004 REF 3.483328800000e-15
Cg005 SIG_005 REF 3.483328800000e-15
Cg006 SIG_006 REF 3.483328800000e-15
Cg007 SIG_007 REF 3.483328800000e-15
Cg008 SIG_008 REF 3.483328800000e-15
Cg009 SIG_009 REF 3.483328800000e-15
Cg010 SIG_RX REF 1.769602800000e-15
.ends ROUTE
