* Educational geometry-derived RC ESTIMATE, not foundry extraction.
* Coefficients and omitted mechanisms: ../../sky130_coefficients.json
.subckt ROUTE SIG_DRV SIG_RX AGG REF
Rseg000 SIG_DRV SIG_001 0.783333333333
Rseg001 SIG_001 SIG_002 0.783333333333
Rseg002 SIG_002 SIG_003 0.783333333333
Rseg003 SIG_003 SIG_004 0.783333333333
Rseg004 SIG_004 SIG_005 0.783333333333
Rseg005 SIG_005 SIG_006 0.783333333333
Rseg006 SIG_006 SIG_007 0.783333333333
Rseg007 SIG_007 SIG_008 0.783333333333
Rseg008 SIG_008 SIG_009 0.783333333333
Rseg009 SIG_009 SIG_010 0.783333333333
Rseg010 SIG_010 SIG_011 0.783333333333
Rseg011 SIG_011 SIG_012 0.783333333333
Rseg012 SIG_012 SIG_013 0.783333333333
Rseg013 SIG_013 SIG_014 0.783333333333
Rseg014 SIG_014 SIG_015 0.783333333333
Rseg015 SIG_015 SIG_016 0.783333333333
Rseg016 SIG_016 SIG_017 0.783333333333
Rseg017 SIG_017 SIG_018 0.783333333333
Rseg018 SIG_018 SIG_019 0.783333333333
Rseg019 SIG_019 SIG_020 0.783333333333
Rseg020 SIG_020 SIG_021 0.783333333333
Rseg021 SIG_021 SIG_022 0.783333333333
Rseg022 SIG_022 SIG_023 0.783333333333
Rseg023 SIG_023 SIG_024 0.783333333333
Rseg024 SIG_024 SIG_025 0.783333333333
Rseg025 SIG_025 SIG_026 0.783333333333
Rseg026 SIG_026 SIG_027 0.783333333333
Rseg027 SIG_027 SIG_028 0.783333333333
Rseg028 SIG_028 SIG_029 0.783333333333
Rseg029 SIG_029 SIG_RX 0.783333333333
Cg000 SIG_DRV REF 2.514968400000e-15
Cg001 SIG_001 REF 4.862306400000e-15
Cg002 SIG_002 REF 4.862306400000e-15
Cg003 SIG_003 REF 4.862306400000e-15
Cc003 SIG_003 AGG 1.008415200000e-15
Cg004 SIG_004 REF 4.862306400000e-15
Cc004 SIG_004 AGG 2.016830400000e-15
Cg005 SIG_005 REF 4.862306400000e-15
Cc005 SIG_005 AGG 2.016830400000e-15
Cg006 SIG_006 REF 4.862306400000e-15
Cc006 SIG_006 AGG 2.016830400000e-15
Cg007 SIG_007 REF 4.862306400000e-15
Cc007 SIG_007 AGG 2.016830400000e-15
Cg008 SIG_008 REF 4.862306400000e-15
Cc008 SIG_008 AGG 2.016830400000e-15
Cg009 SIG_009 REF 4.862306400000e-15
Cc009 SIG_009 AGG 2.016830400000e-15
Cg010 SIG_010 REF 4.862306400000e-15
Cc010 SIG_010 AGG 2.016830400000e-15
Cg011 SIG_011 REF 4.862306400000e-15
Cc011 SIG_011 AGG 2.016830400000e-15
Cg012 SIG_012 REF 4.862306400000e-15
Cc012 SIG_012 AGG 2.016830400000e-15
Cg013 SIG_013 REF 4.862306400000e-15
Cc013 SIG_013 AGG 2.016830400000e-15
Cg014 SIG_014 REF 4.862306400000e-15
Cc014 SIG_014 AGG 2.016830400000e-15
Cg015 SIG_015 REF 4.862306400000e-15
Cc015 SIG_015 AGG 2.016830400000e-15
Cg016 SIG_016 REF 4.862306400000e-15
Cc016 SIG_016 AGG 2.016830400000e-15
Cg017 SIG_017 REF 4.862306400000e-15
Cc017 SIG_017 AGG 2.016830400000e-15
Cg018 SIG_018 REF 4.862306400000e-15
Cc018 SIG_018 AGG 2.016830400000e-15
Cg019 SIG_019 REF 4.862306400000e-15
Cc019 SIG_019 AGG 2.016830400000e-15
Cg020 SIG_020 REF 4.862306400000e-15
Cc020 SIG_020 AGG 2.016830400000e-15
Cg021 SIG_021 REF 4.862306400000e-15
Cc021 SIG_021 AGG 2.016830400000e-15
Cg022 SIG_022 REF 4.862306400000e-15
Cc022 SIG_022 AGG 2.016830400000e-15
Cg023 SIG_023 REF 4.862306400000e-15
Cc023 SIG_023 AGG 2.016830400000e-15
Cg024 SIG_024 REF 4.862306400000e-15
Cc024 SIG_024 AGG 2.016830400000e-15
Cg025 SIG_025 REF 4.862306400000e-15
Cc025 SIG_025 AGG 2.016830400000e-15
Cg026 SIG_026 REF 4.862306400000e-15
Cc026 SIG_026 AGG 2.016830400000e-15
Cg027 SIG_027 REF 4.862306400000e-15
Cc027 SIG_027 AGG 1.008415200000e-15
Cg028 SIG_028 REF 4.862306400000e-15
Cg029 SIG_029 REF 4.862306400000e-15
Cg030 SIG_RX REF 2.514968400000e-15
.ends ROUTE
