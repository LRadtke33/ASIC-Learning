* Lab 4: compact, step. Linear RC model, not a transistor simulation.
.include "../networks/compact.spice"
Vsrc SRC 0 PWL(0 0 2e-09 0 2.2e-09 1.8 6e-08 1.8)
Rsource SRC SIG_DRV 20000.0
Vagg AGG 0 DC 0
Xroute SIG_DRV SIG_RX AGG 0 ROUTE
Cload SIG_RX 0 5.000000000000e-14
.options reltol=1e-7 abstol=1e-14 vntol=1e-10 method=gear maxord=2
.control
set noaskquit
set wr_singlescale
set wr_vecnames
set numdgt=12
tran 1e-11 6e-08 0 1e-11
wrdata ../raw/compact_step.dat v(src) v(sig_drv) v(xroute.sig_005) v(sig_rx) v(agg)
quit
.endc
.end
