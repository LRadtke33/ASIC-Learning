* sky130_fd_sc_hd__dfxtp_1 metastability
.lib "../../../../workspace/learn/learning/labs/common/models/sky130_course.lib.spice" tt
.include "../../../../workspace/learn/learning/labs/analysis_examples/metastability/sky130_fd_sc_hd__dfxtp_1.spice"
.temp 25
.options reltol=1e-7 abstol=1e-15 vntol=1e-9 method=gear maxord=2 rshunt=1e12
VDD VPWR 0 1.8
VSS VGND 0 0
VNB VNB 0 0
VPB VPB 0 1.8
VCLK CLK 0 PULSE(0 1.8 2e-09 2e-11 2e-11 20n 40n)
VD D 0 PULSE(0 1.8 1.8000000000000004e-09 2e-11 2e-11 20n 40n)
XQ CLK D VGND VNB VPB VPWR Q sky130_fd_sc_hd__dfxtp_1
CLOAD Q 0 1.678e-15
.ic v(Q)=0
.control
set wr_vecnames
set wr_singlescale
set numdgt=16
tran 1e-12 5e-09 1.8n 1e-12
wrdata wave.dat v(CLK) v(D) v(Q)
quit
.endc
.end
