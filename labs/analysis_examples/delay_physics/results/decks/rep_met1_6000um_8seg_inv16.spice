* delay physics
.lib "../../../../common/models/sky130_course.lib.spice" tt
.temp 25
.options reltol=1e-5 abstol=1e-14 vntol=1e-8
.subckt inv1 A VGND VNB VPB VPWR Y
XN0 Y A VGND VNB sky130_fd_pr__nfet_01v8 w=0.65 l=0.15
XP0 Y A VPWR VPB sky130_fd_pr__pfet_01v8_hvt w=1.0 l=0.15
.ends
.subckt inv2 A VGND VNB VPB VPWR Y
XN0 Y A VGND VNB sky130_fd_pr__nfet_01v8 w=0.65 l=0.15
XP0 Y A VPWR VPB sky130_fd_pr__pfet_01v8_hvt w=1.0 l=0.15
XN1 Y A VGND VNB sky130_fd_pr__nfet_01v8 w=0.65 l=0.15
XP1 Y A VPWR VPB sky130_fd_pr__pfet_01v8_hvt w=1.0 l=0.15
.ends
.subckt inv4 A VGND VNB VPB VPWR Y
XN0 Y A VGND VNB sky130_fd_pr__nfet_01v8 w=0.65 l=0.15
XP0 Y A VPWR VPB sky130_fd_pr__pfet_01v8_hvt w=1.0 l=0.15
XN1 Y A VGND VNB sky130_fd_pr__nfet_01v8 w=0.65 l=0.15
XP1 Y A VPWR VPB sky130_fd_pr__pfet_01v8_hvt w=1.0 l=0.15
XN2 Y A VGND VNB sky130_fd_pr__nfet_01v8 w=0.65 l=0.15
XP2 Y A VPWR VPB sky130_fd_pr__pfet_01v8_hvt w=1.0 l=0.15
XN3 Y A VGND VNB sky130_fd_pr__nfet_01v8 w=0.65 l=0.15
XP3 Y A VPWR VPB sky130_fd_pr__pfet_01v8_hvt w=1.0 l=0.15
.ends
.subckt inv8 A VGND VNB VPB VPWR Y
XN0 Y A VGND VNB sky130_fd_pr__nfet_01v8 w=0.65 l=0.15
XP0 Y A VPWR VPB sky130_fd_pr__pfet_01v8_hvt w=1.0 l=0.15
XN1 Y A VGND VNB sky130_fd_pr__nfet_01v8 w=0.65 l=0.15
XP1 Y A VPWR VPB sky130_fd_pr__pfet_01v8_hvt w=1.0 l=0.15
XN2 Y A VGND VNB sky130_fd_pr__nfet_01v8 w=0.65 l=0.15
XP2 Y A VPWR VPB sky130_fd_pr__pfet_01v8_hvt w=1.0 l=0.15
XN3 Y A VGND VNB sky130_fd_pr__nfet_01v8 w=0.65 l=0.15
XP3 Y A VPWR VPB sky130_fd_pr__pfet_01v8_hvt w=1.0 l=0.15
XN4 Y A VGND VNB sky130_fd_pr__nfet_01v8 w=0.65 l=0.15
XP4 Y A VPWR VPB sky130_fd_pr__pfet_01v8_hvt w=1.0 l=0.15
XN5 Y A VGND VNB sky130_fd_pr__nfet_01v8 w=0.65 l=0.15
XP5 Y A VPWR VPB sky130_fd_pr__pfet_01v8_hvt w=1.0 l=0.15
XN6 Y A VGND VNB sky130_fd_pr__nfet_01v8 w=0.65 l=0.15
XP6 Y A VPWR VPB sky130_fd_pr__pfet_01v8_hvt w=1.0 l=0.15
XN7 Y A VGND VNB sky130_fd_pr__nfet_01v8 w=0.65 l=0.15
XP7 Y A VPWR VPB sky130_fd_pr__pfet_01v8_hvt w=1.0 l=0.15
.ends
.subckt inv16 A VGND VNB VPB VPWR Y
XN0 Y A VGND VNB sky130_fd_pr__nfet_01v8 w=0.65 l=0.15
XP0 Y A VPWR VPB sky130_fd_pr__pfet_01v8_hvt w=1.0 l=0.15
XN1 Y A VGND VNB sky130_fd_pr__nfet_01v8 w=0.65 l=0.15
XP1 Y A VPWR VPB sky130_fd_pr__pfet_01v8_hvt w=1.0 l=0.15
XN2 Y A VGND VNB sky130_fd_pr__nfet_01v8 w=0.65 l=0.15
XP2 Y A VPWR VPB sky130_fd_pr__pfet_01v8_hvt w=1.0 l=0.15
XN3 Y A VGND VNB sky130_fd_pr__nfet_01v8 w=0.65 l=0.15
XP3 Y A VPWR VPB sky130_fd_pr__pfet_01v8_hvt w=1.0 l=0.15
XN4 Y A VGND VNB sky130_fd_pr__nfet_01v8 w=0.65 l=0.15
XP4 Y A VPWR VPB sky130_fd_pr__pfet_01v8_hvt w=1.0 l=0.15
XN5 Y A VGND VNB sky130_fd_pr__nfet_01v8 w=0.65 l=0.15
XP5 Y A VPWR VPB sky130_fd_pr__pfet_01v8_hvt w=1.0 l=0.15
XN6 Y A VGND VNB sky130_fd_pr__nfet_01v8 w=0.65 l=0.15
XP6 Y A VPWR VPB sky130_fd_pr__pfet_01v8_hvt w=1.0 l=0.15
XN7 Y A VGND VNB sky130_fd_pr__nfet_01v8 w=0.65 l=0.15
XP7 Y A VPWR VPB sky130_fd_pr__pfet_01v8_hvt w=1.0 l=0.15
XN8 Y A VGND VNB sky130_fd_pr__nfet_01v8 w=0.65 l=0.15
XP8 Y A VPWR VPB sky130_fd_pr__pfet_01v8_hvt w=1.0 l=0.15
XN9 Y A VGND VNB sky130_fd_pr__nfet_01v8 w=0.65 l=0.15
XP9 Y A VPWR VPB sky130_fd_pr__pfet_01v8_hvt w=1.0 l=0.15
XN10 Y A VGND VNB sky130_fd_pr__nfet_01v8 w=0.65 l=0.15
XP10 Y A VPWR VPB sky130_fd_pr__pfet_01v8_hvt w=1.0 l=0.15
XN11 Y A VGND VNB sky130_fd_pr__nfet_01v8 w=0.65 l=0.15
XP11 Y A VPWR VPB sky130_fd_pr__pfet_01v8_hvt w=1.0 l=0.15
XN12 Y A VGND VNB sky130_fd_pr__nfet_01v8 w=0.65 l=0.15
XP12 Y A VPWR VPB sky130_fd_pr__pfet_01v8_hvt w=1.0 l=0.15
XN13 Y A VGND VNB sky130_fd_pr__nfet_01v8 w=0.65 l=0.15
XP13 Y A VPWR VPB sky130_fd_pr__pfet_01v8_hvt w=1.0 l=0.15
XN14 Y A VGND VNB sky130_fd_pr__nfet_01v8 w=0.65 l=0.15
XP14 Y A VPWR VPB sky130_fd_pr__pfet_01v8_hvt w=1.0 l=0.15
XN15 Y A VGND VNB sky130_fd_pr__nfet_01v8 w=0.65 l=0.15
XP15 Y A VPWR VPB sky130_fd_pr__pfet_01v8_hvt w=1.0 l=0.15
.ends
VDD vdd 0 1.8
VIN in 0 PULSE(0 1.8 0.3n 20p 20p 7n 14n)
XS0 in 0 0 vdd vdd s0 inv1
XS1 s0 0 0 vdd vdd a inv4
XDRV0 a 0 0 vdd vdd y0_0 inv16
RUP0 y0_0 w0_0 152.0
CA0_0 w0_0 0 4.5375f
RW0_0 w0_0 w0_1 95.66326530612244
CB0_0 w0_1 0 4.5375f
CA0_1 w0_1 0 4.5375f
RW0_1 w0_1 w0_2 95.66326530612244
CB0_1 w0_2 0 4.5375f
CA0_2 w0_2 0 4.5375f
RW0_2 w0_2 w0_3 95.66326530612244
CB0_2 w0_3 0 4.5375f
CA0_3 w0_3 0 4.5375f
RW0_3 w0_3 w0_4 95.66326530612244
CB0_3 w0_4 0 4.5375f
CA0_4 w0_4 0 4.5375f
RW0_4 w0_4 w0_5 95.66326530612244
CB0_4 w0_5 0 4.5375f
CA0_5 w0_5 0 4.5375f
RW0_5 w0_5 w0_6 95.66326530612244
CB0_5 w0_6 0 4.5375f
CA0_6 w0_6 0 4.5375f
RW0_6 w0_6 w0_7 95.66326530612244
CB0_6 w0_7 0 4.5375f
RDN0 w0_7 g0 152.0
XR0 g0 0 0 vdd vdd y1_0 inv16
RUP1 y1_0 w1_0 152.0
CA1_0 w1_0 0 4.5375f
RW1_0 w1_0 w1_1 95.66326530612244
CB1_0 w1_1 0 4.5375f
CA1_1 w1_1 0 4.5375f
RW1_1 w1_1 w1_2 95.66326530612244
CB1_1 w1_2 0 4.5375f
CA1_2 w1_2 0 4.5375f
RW1_2 w1_2 w1_3 95.66326530612244
CB1_2 w1_3 0 4.5375f
CA1_3 w1_3 0 4.5375f
RW1_3 w1_3 w1_4 95.66326530612244
CB1_3 w1_4 0 4.5375f
CA1_4 w1_4 0 4.5375f
RW1_4 w1_4 w1_5 95.66326530612244
CB1_4 w1_5 0 4.5375f
CA1_5 w1_5 0 4.5375f
RW1_5 w1_5 w1_6 95.66326530612244
CB1_5 w1_6 0 4.5375f
CA1_6 w1_6 0 4.5375f
RW1_6 w1_6 w1_7 95.66326530612244
CB1_6 w1_7 0 4.5375f
RDN1 w1_7 g1 152.0
XR1 g1 0 0 vdd vdd y2_0 inv16
RUP2 y2_0 w2_0 152.0
CA2_0 w2_0 0 4.5375f
RW2_0 w2_0 w2_1 95.66326530612244
CB2_0 w2_1 0 4.5375f
CA2_1 w2_1 0 4.5375f
RW2_1 w2_1 w2_2 95.66326530612244
CB2_1 w2_2 0 4.5375f
CA2_2 w2_2 0 4.5375f
RW2_2 w2_2 w2_3 95.66326530612244
CB2_2 w2_3 0 4.5375f
CA2_3 w2_3 0 4.5375f
RW2_3 w2_3 w2_4 95.66326530612244
CB2_3 w2_4 0 4.5375f
CA2_4 w2_4 0 4.5375f
RW2_4 w2_4 w2_5 95.66326530612244
CB2_4 w2_5 0 4.5375f
CA2_5 w2_5 0 4.5375f
RW2_5 w2_5 w2_6 95.66326530612244
CB2_5 w2_6 0 4.5375f
CA2_6 w2_6 0 4.5375f
RW2_6 w2_6 w2_7 95.66326530612244
CB2_6 w2_7 0 4.5375f
RDN2 w2_7 g2 152.0
XR2 g2 0 0 vdd vdd y3_0 inv16
RUP3 y3_0 w3_0 152.0
CA3_0 w3_0 0 4.5375f
RW3_0 w3_0 w3_1 95.66326530612244
CB3_0 w3_1 0 4.5375f
CA3_1 w3_1 0 4.5375f
RW3_1 w3_1 w3_2 95.66326530612244
CB3_1 w3_2 0 4.5375f
CA3_2 w3_2 0 4.5375f
RW3_2 w3_2 w3_3 95.66326530612244
CB3_2 w3_3 0 4.5375f
CA3_3 w3_3 0 4.5375f
RW3_3 w3_3 w3_4 95.66326530612244
CB3_3 w3_4 0 4.5375f
CA3_4 w3_4 0 4.5375f
RW3_4 w3_4 w3_5 95.66326530612244
CB3_4 w3_5 0 4.5375f
CA3_5 w3_5 0 4.5375f
RW3_5 w3_5 w3_6 95.66326530612244
CB3_5 w3_6 0 4.5375f
CA3_6 w3_6 0 4.5375f
RW3_6 w3_6 w3_7 95.66326530612244
CB3_6 w3_7 0 4.5375f
RDN3 w3_7 g3 152.0
XR3 g3 0 0 vdd vdd y4_0 inv16
RUP4 y4_0 w4_0 152.0
CA4_0 w4_0 0 4.5375f
RW4_0 w4_0 w4_1 95.66326530612244
CB4_0 w4_1 0 4.5375f
CA4_1 w4_1 0 4.5375f
RW4_1 w4_1 w4_2 95.66326530612244
CB4_1 w4_2 0 4.5375f
CA4_2 w4_2 0 4.5375f
RW4_2 w4_2 w4_3 95.66326530612244
CB4_2 w4_3 0 4.5375f
CA4_3 w4_3 0 4.5375f
RW4_3 w4_3 w4_4 95.66326530612244
CB4_3 w4_4 0 4.5375f
CA4_4 w4_4 0 4.5375f
RW4_4 w4_4 w4_5 95.66326530612244
CB4_4 w4_5 0 4.5375f
CA4_5 w4_5 0 4.5375f
RW4_5 w4_5 w4_6 95.66326530612244
CB4_5 w4_6 0 4.5375f
CA4_6 w4_6 0 4.5375f
RW4_6 w4_6 w4_7 95.66326530612244
CB4_6 w4_7 0 4.5375f
RDN4 w4_7 g4 152.0
XR4 g4 0 0 vdd vdd y5_0 inv16
RUP5 y5_0 w5_0 152.0
CA5_0 w5_0 0 4.5375f
RW5_0 w5_0 w5_1 95.66326530612244
CB5_0 w5_1 0 4.5375f
CA5_1 w5_1 0 4.5375f
RW5_1 w5_1 w5_2 95.66326530612244
CB5_1 w5_2 0 4.5375f
CA5_2 w5_2 0 4.5375f
RW5_2 w5_2 w5_3 95.66326530612244
CB5_2 w5_3 0 4.5375f
CA5_3 w5_3 0 4.5375f
RW5_3 w5_3 w5_4 95.66326530612244
CB5_3 w5_4 0 4.5375f
CA5_4 w5_4 0 4.5375f
RW5_4 w5_4 w5_5 95.66326530612244
CB5_4 w5_5 0 4.5375f
CA5_5 w5_5 0 4.5375f
RW5_5 w5_5 w5_6 95.66326530612244
CB5_5 w5_6 0 4.5375f
CA5_6 w5_6 0 4.5375f
RW5_6 w5_6 w5_7 95.66326530612244
CB5_6 w5_7 0 4.5375f
RDN5 w5_7 g5 152.0
XR5 g5 0 0 vdd vdd y6_0 inv16
RUP6 y6_0 w6_0 152.0
CA6_0 w6_0 0 4.5375f
RW6_0 w6_0 w6_1 95.66326530612244
CB6_0 w6_1 0 4.5375f
CA6_1 w6_1 0 4.5375f
RW6_1 w6_1 w6_2 95.66326530612244
CB6_1 w6_2 0 4.5375f
CA6_2 w6_2 0 4.5375f
RW6_2 w6_2 w6_3 95.66326530612244
CB6_2 w6_3 0 4.5375f
CA6_3 w6_3 0 4.5375f
RW6_3 w6_3 w6_4 95.66326530612244
CB6_3 w6_4 0 4.5375f
CA6_4 w6_4 0 4.5375f
RW6_4 w6_4 w6_5 95.66326530612244
CB6_4 w6_5 0 4.5375f
CA6_5 w6_5 0 4.5375f
RW6_5 w6_5 w6_6 95.66326530612244
CB6_5 w6_6 0 4.5375f
CA6_6 w6_6 0 4.5375f
RW6_6 w6_6 w6_7 95.66326530612244
CB6_6 w6_7 0 4.5375f
RDN6 w6_7 g6 152.0
XR6 g6 0 0 vdd vdd y7_0 inv16
RUP7 y7_0 w7_0 152.0
CA7_0 w7_0 0 4.5375f
RW7_0 w7_0 w7_1 95.66326530612244
CB7_0 w7_1 0 4.5375f
CA7_1 w7_1 0 4.5375f
RW7_1 w7_1 w7_2 95.66326530612244
CB7_1 w7_2 0 4.5375f
CA7_2 w7_2 0 4.5375f
RW7_2 w7_2 w7_3 95.66326530612244
CB7_2 w7_3 0 4.5375f
CA7_3 w7_3 0 4.5375f
RW7_3 w7_3 w7_4 95.66326530612244
CB7_3 w7_4 0 4.5375f
CA7_4 w7_4 0 4.5375f
RW7_4 w7_4 w7_5 95.66326530612244
CB7_4 w7_5 0 4.5375f
CA7_5 w7_5 0 4.5375f
RW7_5 w7_5 w7_6 95.66326530612244
CB7_5 w7_6 0 4.5375f
CA7_6 w7_6 0 4.5375f
RW7_6 w7_6 w7_7 95.66326530612244
CB7_6 w7_7 0 4.5375f
RDN7 w7_7 g7 152.0
XLD g7 0 0 vdd vdd z inv1
CZ z 0 9.208f

.control
set wr_vecnames
set wr_singlescale
set numdgt=10
tran 0.5p 16n 0 0.5p
wrdata tran.dat v(a) v(g7)
quit
.endc
.end
