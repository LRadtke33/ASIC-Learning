* leakage
.lib "../../../../common/models/sky130_course.lib.spice" tt
.temp 25
.options reltol=1e-5 abstol=1e-14 vntol=1e-8
.subckt inv1 A VGND VNB VPB VPWR Y
XN0 Y A VGND VNB sky130_fd_pr__nfet_01v8 w=0.65 l=0.15
XP0 Y A VPWR VPB sky130_fd_pr__pfet_01v8_hvt w=1.0 l=0.15
.ends
.subckt inv2 A VGND VNB VPB VPWR Y
XN0 Y A VGND VNB sky130_fd_pr__nfet_01v8 w=0.65 l=0.15
XP0 Y A VPWR VPB sky130_fd_pr__pfet_01v8_hvt w=1.0 l=0.15
XN1 Y A VGND VNB sky130_fd_pr__nfet_01v8 w=0.65 l=0.15
XP1 Y A VPWR VPB sky130_fd_pr__pfet_01v8_hvt w=1.0 l=0.15
.ends
.subckt inv4 A VGND VNB VPB VPWR Y
XN0 Y A VGND VNB sky130_fd_pr__nfet_01v8 w=0.65 l=0.15
XP0 Y A VPWR VPB sky130_fd_pr__pfet_01v8_hvt w=1.0 l=0.15
XN1 Y A VGND VNB sky130_fd_pr__nfet_01v8 w=0.65 l=0.15
XP1 Y A VPWR VPB sky130_fd_pr__pfet_01v8_hvt w=1.0 l=0.15
XN2 Y A VGND VNB sky130_fd_pr__nfet_01v8 w=0.65 l=0.15
XP2 Y A VPWR VPB sky130_fd_pr__pfet_01v8_hvt w=1.0 l=0.15
XN3 Y A VGND VNB sky130_fd_pr__nfet_01v8 w=0.65 l=0.15
XP3 Y A VPWR VPB sky130_fd_pr__pfet_01v8_hvt w=1.0 l=0.15
.ends
.subckt inv8 A VGND VNB VPB VPWR Y
XN0 Y A VGND VNB sky130_fd_pr__nfet_01v8 w=0.65 l=0.15
XP0 Y A VPWR VPB sky130_fd_pr__pfet_01v8_hvt w=1.0 l=0.15
XN1 Y A VGND VNB sky130_fd_pr__nfet_01v8 w=0.65 l=0.15
XP1 Y A VPWR VPB sky130_fd_pr__pfet_01v8_hvt w=1.0 l=0.15
XN2 Y A VGND VNB sky130_fd_pr__nfet_01v8 w=0.65 l=0.15
XP2 Y A VPWR VPB sky130_fd_pr__pfet_01v8_hvt w=1.0 l=0.15
XN3 Y A VGND VNB sky130_fd_pr__nfet_01v8 w=0.65 l=0.15
XP3 Y A VPWR VPB sky130_fd_pr__pfet_01v8_hvt w=1.0 l=0.15
XN4 Y A VGND VNB sky130_fd_pr__nfet_01v8 w=0.65 l=0.15
XP4 Y A VPWR VPB sky130_fd_pr__pfet_01v8_hvt w=1.0 l=0.15
XN5 Y A VGND VNB sky130_fd_pr__nfet_01v8 w=0.65 l=0.15
XP5 Y A VPWR VPB sky130_fd_pr__pfet_01v8_hvt w=1.0 l=0.15
XN6 Y A VGND VNB sky130_fd_pr__nfet_01v8 w=0.65 l=0.15
XP6 Y A VPWR VPB sky130_fd_pr__pfet_01v8_hvt w=1.0 l=0.15
XN7 Y A VGND VNB sky130_fd_pr__nfet_01v8 w=0.65 l=0.15
XP7 Y A VPWR VPB sky130_fd_pr__pfet_01v8_hvt w=1.0 l=0.15
.ends
.subckt inv16 A VGND VNB VPB VPWR Y
XN0 Y A VGND VNB sky130_fd_pr__nfet_01v8 w=0.65 l=0.15
XP0 Y A VPWR VPB sky130_fd_pr__pfet_01v8_hvt w=1.0 l=0.15
XN1 Y A VGND VNB sky130_fd_pr__nfet_01v8 w=0.65 l=0.15
XP1 Y A VPWR VPB sky130_fd_pr__pfet_01v8_hvt w=1.0 l=0.15
XN2 Y A VGND VNB sky130_fd_pr__nfet_01v8 w=0.65 l=0.15
XP2 Y A VPWR VPB sky130_fd_pr__pfet_01v8_hvt w=1.0 l=0.15
XN3 Y A VGND VNB sky130_fd_pr__nfet_01v8 w=0.65 l=0.15
XP3 Y A VPWR VPB sky130_fd_pr__pfet_01v8_hvt w=1.0 l=0.15
XN4 Y A VGND VNB sky130_fd_pr__nfet_01v8 w=0.65 l=0.15
XP4 Y A VPWR VPB sky130_fd_pr__pfet_01v8_hvt w=1.0 l=0.15
XN5 Y A VGND VNB sky130_fd_pr__nfet_01v8 w=0.65 l=0.15
XP5 Y A VPWR VPB sky130_fd_pr__pfet_01v8_hvt w=1.0 l=0.15
XN6 Y A VGND VNB sky130_fd_pr__nfet_01v8 w=0.65 l=0.15
XP6 Y A VPWR VPB sky130_fd_pr__pfet_01v8_hvt w=1.0 l=0.15
XN7 Y A VGND VNB sky130_fd_pr__nfet_01v8 w=0.65 l=0.15
XP7 Y A VPWR VPB sky130_fd_pr__pfet_01v8_hvt w=1.0 l=0.15
XN8 Y A VGND VNB sky130_fd_pr__nfet_01v8 w=0.65 l=0.15
XP8 Y A VPWR VPB sky130_fd_pr__pfet_01v8_hvt w=1.0 l=0.15
XN9 Y A VGND VNB sky130_fd_pr__nfet_01v8 w=0.65 l=0.15
XP9 Y A VPWR VPB sky130_fd_pr__pfet_01v8_hvt w=1.0 l=0.15
XN10 Y A VGND VNB sky130_fd_pr__nfet_01v8 w=0.65 l=0.15
XP10 Y A VPWR VPB sky130_fd_pr__pfet_01v8_hvt w=1.0 l=0.15
XN11 Y A VGND VNB sky130_fd_pr__nfet_01v8 w=0.65 l=0.15
XP11 Y A VPWR VPB sky130_fd_pr__pfet_01v8_hvt w=1.0 l=0.15
XN12 Y A VGND VNB sky130_fd_pr__nfet_01v8 w=0.65 l=0.15
XP12 Y A VPWR VPB sky130_fd_pr__pfet_01v8_hvt w=1.0 l=0.15
XN13 Y A VGND VNB sky130_fd_pr__nfet_01v8 w=0.65 l=0.15
XP13 Y A VPWR VPB sky130_fd_pr__pfet_01v8_hvt w=1.0 l=0.15
XN14 Y A VGND VNB sky130_fd_pr__nfet_01v8 w=0.65 l=0.15
XP14 Y A VPWR VPB sky130_fd_pr__pfet_01v8_hvt w=1.0 l=0.15
XN15 Y A VGND VNB sky130_fd_pr__nfet_01v8 w=0.65 l=0.15
XP15 Y A VPWR VPB sky130_fd_pr__pfet_01v8_hvt w=1.0 l=0.15
.ends
VDD vdd 0 1.4
VA0 a0 0 0
VA1 a1 0 1.4
VD0 vd0 0 1.4
VD1 vd1 0 1.4
X0 a0 0 0 vd0 vd0 y0 inv1
X1 a1 0 0 vd1 vd1 y1 inv1

.control
op
print i(VD0) i(VD1)
quit
.endc
.end
