* delay physics
.lib "../../../../common/models/sky130_course.lib.spice" tt
.temp 25
.options reltol=1e-5 abstol=1e-14 vntol=1e-8
.subckt inv1 A VGND VNB VPB VPWR Y
XN0 Y A VGND VNB sky130_fd_pr__nfet_01v8 w=0.65 l=0.15
XP0 Y A VPWR VPB sky130_fd_pr__pfet_01v8_hvt w=1.0 l=0.15
.ends
.subckt inv2 A VGND VNB VPB VPWR Y
XN0 Y A VGND VNB sky130_fd_pr__nfet_01v8 w=0.65 l=0.15
XP0 Y A VPWR VPB sky130_fd_pr__pfet_01v8_hvt w=1.0 l=0.15
XN1 Y A VGND VNB sky130_fd_pr__nfet_01v8 w=0.65 l=0.15
XP1 Y A VPWR VPB sky130_fd_pr__pfet_01v8_hvt w=1.0 l=0.15
.ends
.subckt inv4 A VGND VNB VPB VPWR Y
XN0 Y A VGND VNB sky130_fd_pr__nfet_01v8 w=0.65 l=0.15
XP0 Y A VPWR VPB sky130_fd_pr__pfet_01v8_hvt w=1.0 l=0.15
XN1 Y A VGND VNB sky130_fd_pr__nfet_01v8 w=0.65 l=0.15
XP1 Y A VPWR VPB sky130_fd_pr__pfet_01v8_hvt w=1.0 l=0.15
XN2 Y A VGND VNB sky130_fd_pr__nfet_01v8 w=0.65 l=0.15
XP2 Y A VPWR VPB sky130_fd_pr__pfet_01v8_hvt w=1.0 l=0.15
XN3 Y A VGND VNB sky130_fd_pr__nfet_01v8 w=0.65 l=0.15
XP3 Y A VPWR VPB sky130_fd_pr__pfet_01v8_hvt w=1.0 l=0.15
.ends
.subckt inv8 A VGND VNB VPB VPWR Y
XN0 Y A VGND VNB sky130_fd_pr__nfet_01v8 w=0.65 l=0.15
XP0 Y A VPWR VPB sky130_fd_pr__pfet_01v8_hvt w=1.0 l=0.15
XN1 Y A VGND VNB sky130_fd_pr__nfet_01v8 w=0.65 l=0.15
XP1 Y A VPWR VPB sky130_fd_pr__pfet_01v8_hvt w=1.0 l=0.15
XN2 Y A VGND VNB sky130_fd_pr__nfet_01v8 w=0.65 l=0.15
XP2 Y A VPWR VPB sky130_fd_pr__pfet_01v8_hvt w=1.0 l=0.15
XN3 Y A VGND VNB sky130_fd_pr__nfet_01v8 w=0.65 l=0.15
XP3 Y A VPWR VPB sky130_fd_pr__pfet_01v8_hvt w=1.0 l=0.15
XN4 Y A VGND VNB sky130_fd_pr__nfet_01v8 w=0.65 l=0.15
XP4 Y A VPWR VPB sky130_fd_pr__pfet_01v8_hvt w=1.0 l=0.15
XN5 Y A VGND VNB sky130_fd_pr__nfet_01v8 w=0.65 l=0.15
XP5 Y A VPWR VPB sky130_fd_pr__pfet_01v8_hvt w=1.0 l=0.15
XN6 Y A VGND VNB sky130_fd_pr__nfet_01v8 w=0.65 l=0.15
XP6 Y A VPWR VPB sky130_fd_pr__pfet_01v8_hvt w=1.0 l=0.15
XN7 Y A VGND VNB sky130_fd_pr__nfet_01v8 w=0.65 l=0.15
XP7 Y A VPWR VPB sky130_fd_pr__pfet_01v8_hvt w=1.0 l=0.15
.ends
.subckt inv16 A VGND VNB VPB VPWR Y
XN0 Y A VGND VNB sky130_fd_pr__nfet_01v8 w=0.65 l=0.15
XP0 Y A VPWR VPB sky130_fd_pr__pfet_01v8_hvt w=1.0 l=0.15
XN1 Y A VGND VNB sky130_fd_pr__nfet_01v8 w=0.65 l=0.15
XP1 Y A VPWR VPB sky130_fd_pr__pfet_01v8_hvt w=1.0 l=0.15
XN2 Y A VGND VNB sky130_fd_pr__nfet_01v8 w=0.65 l=0.15
XP2 Y A VPWR VPB sky130_fd_pr__pfet_01v8_hvt w=1.0 l=0.15
XN3 Y A VGND VNB sky130_fd_pr__nfet_01v8 w=0.65 l=0.15
XP3 Y A VPWR VPB sky130_fd_pr__pfet_01v8_hvt w=1.0 l=0.15
XN4 Y A VGND VNB sky130_fd_pr__nfet_01v8 w=0.65 l=0.15
XP4 Y A VPWR VPB sky130_fd_pr__pfet_01v8_hvt w=1.0 l=0.15
XN5 Y A VGND VNB sky130_fd_pr__nfet_01v8 w=0.65 l=0.15
XP5 Y A VPWR VPB sky130_fd_pr__pfet_01v8_hvt w=1.0 l=0.15
XN6 Y A VGND VNB sky130_fd_pr__nfet_01v8 w=0.65 l=0.15
XP6 Y A VPWR VPB sky130_fd_pr__pfet_01v8_hvt w=1.0 l=0.15
XN7 Y A VGND VNB sky130_fd_pr__nfet_01v8 w=0.65 l=0.15
XP7 Y A VPWR VPB sky130_fd_pr__pfet_01v8_hvt w=1.0 l=0.15
XN8 Y A VGND VNB sky130_fd_pr__nfet_01v8 w=0.65 l=0.15
XP8 Y A VPWR VPB sky130_fd_pr__pfet_01v8_hvt w=1.0 l=0.15
XN9 Y A VGND VNB sky130_fd_pr__nfet_01v8 w=0.65 l=0.15
XP9 Y A VPWR VPB sky130_fd_pr__pfet_01v8_hvt w=1.0 l=0.15
XN10 Y A VGND VNB sky130_fd_pr__nfet_01v8 w=0.65 l=0.15
XP10 Y A VPWR VPB sky130_fd_pr__pfet_01v8_hvt w=1.0 l=0.15
XN11 Y A VGND VNB sky130_fd_pr__nfet_01v8 w=0.65 l=0.15
XP11 Y A VPWR VPB sky130_fd_pr__pfet_01v8_hvt w=1.0 l=0.15
XN12 Y A VGND VNB sky130_fd_pr__nfet_01v8 w=0.65 l=0.15
XP12 Y A VPWR VPB sky130_fd_pr__pfet_01v8_hvt w=1.0 l=0.15
XN13 Y A VGND VNB sky130_fd_pr__nfet_01v8 w=0.65 l=0.15
XP13 Y A VPWR VPB sky130_fd_pr__pfet_01v8_hvt w=1.0 l=0.15
XN14 Y A VGND VNB sky130_fd_pr__nfet_01v8 w=0.65 l=0.15
XP14 Y A VPWR VPB sky130_fd_pr__pfet_01v8_hvt w=1.0 l=0.15
XN15 Y A VGND VNB sky130_fd_pr__nfet_01v8 w=0.65 l=0.15
XP15 Y A VPWR VPB sky130_fd_pr__pfet_01v8_hvt w=1.0 l=0.15
.ends
VDD vdd 0 1.8
VIN in 0 PULSE(0 1.8 0.3n 20p 20p 7n 14n)
XS0 in 0 0 vdd vdd s0 inv1
XS1 s0 0 0 vdd vdd a inv4
XDRV0 a 0 0 vdd vdd y0_0 inv16
RUP0 y0_0 w0_0 152.0
CA0_0 w0_0 0 4.235f
RW0_0 w0_0 w0_1 89.28571428571428
CB0_0 w0_1 0 4.235f
CA0_1 w0_1 0 4.235f
RW0_1 w0_1 w0_2 89.28571428571428
CB0_1 w0_2 0 4.235f
CA0_2 w0_2 0 4.235f
RW0_2 w0_2 w0_3 89.28571428571428
CB0_2 w0_3 0 4.235f
CA0_3 w0_3 0 4.235f
RW0_3 w0_3 w0_4 89.28571428571428
CB0_3 w0_4 0 4.235f
CA0_4 w0_4 0 4.235f
RW0_4 w0_4 w0_5 89.28571428571428
CB0_4 w0_5 0 4.235f
CA0_5 w0_5 0 4.235f
RW0_5 w0_5 w0_6 89.28571428571428
CB0_5 w0_6 0 4.235f
CA0_6 w0_6 0 4.235f
RW0_6 w0_6 w0_7 89.28571428571428
CB0_6 w0_7 0 4.235f
CA0_7 w0_7 0 4.235f
RW0_7 w0_7 w0_8 89.28571428571428
CB0_7 w0_8 0 4.235f
CA0_8 w0_8 0 4.235f
RW0_8 w0_8 w0_9 89.28571428571428
CB0_8 w0_9 0 4.235f
CA0_9 w0_9 0 4.235f
RW0_9 w0_9 w0_10 89.28571428571428
CB0_9 w0_10 0 4.235f
CA0_10 w0_10 0 4.235f
RW0_10 w0_10 w0_11 89.28571428571428
CB0_10 w0_11 0 4.235f
CA0_11 w0_11 0 4.235f
RW0_11 w0_11 w0_12 89.28571428571428
CB0_11 w0_12 0 4.235f
CA0_12 w0_12 0 4.235f
RW0_12 w0_12 w0_13 89.28571428571428
CB0_12 w0_13 0 4.235f
CA0_13 w0_13 0 4.235f
RW0_13 w0_13 w0_14 89.28571428571428
CB0_13 w0_14 0 4.235f
CA0_14 w0_14 0 4.235f
RW0_14 w0_14 w0_15 89.28571428571428
CB0_14 w0_15 0 4.235f
CA0_15 w0_15 0 4.235f
RW0_15 w0_15 w0_16 89.28571428571428
CB0_15 w0_16 0 4.235f
CA0_16 w0_16 0 4.235f
RW0_16 w0_16 w0_17 89.28571428571428
CB0_16 w0_17 0 4.235f
CA0_17 w0_17 0 4.235f
RW0_17 w0_17 w0_18 89.28571428571428
CB0_17 w0_18 0 4.235f
CA0_18 w0_18 0 4.235f
RW0_18 w0_18 w0_19 89.28571428571428
CB0_18 w0_19 0 4.235f
CA0_19 w0_19 0 4.235f
RW0_19 w0_19 w0_20 89.28571428571428
CB0_19 w0_20 0 4.235f
CA0_20 w0_20 0 4.235f
RW0_20 w0_20 w0_21 89.28571428571428
CB0_20 w0_21 0 4.235f
CA0_21 w0_21 0 4.235f
RW0_21 w0_21 w0_22 89.28571428571428
CB0_21 w0_22 0 4.235f
CA0_22 w0_22 0 4.235f
RW0_22 w0_22 w0_23 89.28571428571428
CB0_22 w0_23 0 4.235f
CA0_23 w0_23 0 4.235f
RW0_23 w0_23 w0_24 89.28571428571428
CB0_23 w0_24 0 4.235f
CA0_24 w0_24 0 4.235f
RW0_24 w0_24 w0_25 89.28571428571428
CB0_24 w0_25 0 4.235f
CA0_25 w0_25 0 4.235f
RW0_25 w0_25 w0_26 89.28571428571428
CB0_25 w0_26 0 4.235f
CA0_26 w0_26 0 4.235f
RW0_26 w0_26 w0_27 89.28571428571428
CB0_26 w0_27 0 4.235f
CA0_27 w0_27 0 4.235f
RW0_27 w0_27 w0_28 89.28571428571428
CB0_27 w0_28 0 4.235f
CA0_28 w0_28 0 4.235f
RW0_28 w0_28 w0_29 89.28571428571428
CB0_28 w0_29 0 4.235f
CA0_29 w0_29 0 4.235f
RW0_29 w0_29 w0_30 89.28571428571428
CB0_29 w0_30 0 4.235f
RDN0 w0_30 g0 152.0
XR0 g0 0 0 vdd vdd y1_0 inv16
RUP1 y1_0 w1_0 152.0
CA1_0 w1_0 0 4.235f
RW1_0 w1_0 w1_1 89.28571428571428
CB1_0 w1_1 0 4.235f
CA1_1 w1_1 0 4.235f
RW1_1 w1_1 w1_2 89.28571428571428
CB1_1 w1_2 0 4.235f
CA1_2 w1_2 0 4.235f
RW1_2 w1_2 w1_3 89.28571428571428
CB1_2 w1_3 0 4.235f
CA1_3 w1_3 0 4.235f
RW1_3 w1_3 w1_4 89.28571428571428
CB1_3 w1_4 0 4.235f
CA1_4 w1_4 0 4.235f
RW1_4 w1_4 w1_5 89.28571428571428
CB1_4 w1_5 0 4.235f
CA1_5 w1_5 0 4.235f
RW1_5 w1_5 w1_6 89.28571428571428
CB1_5 w1_6 0 4.235f
CA1_6 w1_6 0 4.235f
RW1_6 w1_6 w1_7 89.28571428571428
CB1_6 w1_7 0 4.235f
CA1_7 w1_7 0 4.235f
RW1_7 w1_7 w1_8 89.28571428571428
CB1_7 w1_8 0 4.235f
CA1_8 w1_8 0 4.235f
RW1_8 w1_8 w1_9 89.28571428571428
CB1_8 w1_9 0 4.235f
CA1_9 w1_9 0 4.235f
RW1_9 w1_9 w1_10 89.28571428571428
CB1_9 w1_10 0 4.235f
CA1_10 w1_10 0 4.235f
RW1_10 w1_10 w1_11 89.28571428571428
CB1_10 w1_11 0 4.235f
CA1_11 w1_11 0 4.235f
RW1_11 w1_11 w1_12 89.28571428571428
CB1_11 w1_12 0 4.235f
CA1_12 w1_12 0 4.235f
RW1_12 w1_12 w1_13 89.28571428571428
CB1_12 w1_13 0 4.235f
CA1_13 w1_13 0 4.235f
RW1_13 w1_13 w1_14 89.28571428571428
CB1_13 w1_14 0 4.235f
CA1_14 w1_14 0 4.235f
RW1_14 w1_14 w1_15 89.28571428571428
CB1_14 w1_15 0 4.235f
CA1_15 w1_15 0 4.235f
RW1_15 w1_15 w1_16 89.28571428571428
CB1_15 w1_16 0 4.235f
CA1_16 w1_16 0 4.235f
RW1_16 w1_16 w1_17 89.28571428571428
CB1_16 w1_17 0 4.235f
CA1_17 w1_17 0 4.235f
RW1_17 w1_17 w1_18 89.28571428571428
CB1_17 w1_18 0 4.235f
CA1_18 w1_18 0 4.235f
RW1_18 w1_18 w1_19 89.28571428571428
CB1_18 w1_19 0 4.235f
CA1_19 w1_19 0 4.235f
RW1_19 w1_19 w1_20 89.28571428571428
CB1_19 w1_20 0 4.235f
CA1_20 w1_20 0 4.235f
RW1_20 w1_20 w1_21 89.28571428571428
CB1_20 w1_21 0 4.235f
CA1_21 w1_21 0 4.235f
RW1_21 w1_21 w1_22 89.28571428571428
CB1_21 w1_22 0 4.235f
CA1_22 w1_22 0 4.235f
RW1_22 w1_22 w1_23 89.28571428571428
CB1_22 w1_23 0 4.235f
CA1_23 w1_23 0 4.235f
RW1_23 w1_23 w1_24 89.28571428571428
CB1_23 w1_24 0 4.235f
CA1_24 w1_24 0 4.235f
RW1_24 w1_24 w1_25 89.28571428571428
CB1_24 w1_25 0 4.235f
CA1_25 w1_25 0 4.235f
RW1_25 w1_25 w1_26 89.28571428571428
CB1_25 w1_26 0 4.235f
CA1_26 w1_26 0 4.235f
RW1_26 w1_26 w1_27 89.28571428571428
CB1_26 w1_27 0 4.235f
CA1_27 w1_27 0 4.235f
RW1_27 w1_27 w1_28 89.28571428571428
CB1_27 w1_28 0 4.235f
CA1_28 w1_28 0 4.235f
RW1_28 w1_28 w1_29 89.28571428571428
CB1_28 w1_29 0 4.235f
CA1_29 w1_29 0 4.235f
RW1_29 w1_29 w1_30 89.28571428571428
CB1_29 w1_30 0 4.235f
RDN1 w1_30 g1 152.0
XLD g1 0 0 vdd vdd z inv1
CZ z 0 9.208f

.control
set wr_vecnames
set wr_singlescale
set numdgt=10
tran 0.5p 16n 0 0.5p
wrdata tran.dat v(a) v(g1)
quit
.endc
.end
