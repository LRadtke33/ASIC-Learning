* delay physics
.lib "../../../../common/models/sky130_course.lib.spice" tt
.temp 25
.options reltol=1e-5 abstol=1e-14 vntol=1e-8
.subckt inv1 A VGND VNB VPB VPWR Y
XN0 Y A VGND VNB sky130_fd_pr__nfet_01v8 w=0.65 l=0.15
XP0 Y A VPWR VPB sky130_fd_pr__pfet_01v8_hvt w=1.0 l=0.15
.ends
.subckt inv2 A VGND VNB VPB VPWR Y
XN0 Y A VGND VNB sky130_fd_pr__nfet_01v8 w=0.65 l=0.15
XP0 Y A VPWR VPB sky130_fd_pr__pfet_01v8_hvt w=1.0 l=0.15
XN1 Y A VGND VNB sky130_fd_pr__nfet_01v8 w=0.65 l=0.15
XP1 Y A VPWR VPB sky130_fd_pr__pfet_01v8_hvt w=1.0 l=0.15
.ends
.subckt inv4 A VGND VNB VPB VPWR Y
XN0 Y A VGND VNB sky130_fd_pr__nfet_01v8 w=0.65 l=0.15
XP0 Y A VPWR VPB sky130_fd_pr__pfet_01v8_hvt w=1.0 l=0.15
XN1 Y A VGND VNB sky130_fd_pr__nfet_01v8 w=0.65 l=0.15
XP1 Y A VPWR VPB sky130_fd_pr__pfet_01v8_hvt w=1.0 l=0.15
XN2 Y A VGND VNB sky130_fd_pr__nfet_01v8 w=0.65 l=0.15
XP2 Y A VPWR VPB sky130_fd_pr__pfet_01v8_hvt w=1.0 l=0.15
XN3 Y A VGND VNB sky130_fd_pr__nfet_01v8 w=0.65 l=0.15
XP3 Y A VPWR VPB sky130_fd_pr__pfet_01v8_hvt w=1.0 l=0.15
.ends
.subckt inv8 A VGND VNB VPB VPWR Y
XN0 Y A VGND VNB sky130_fd_pr__nfet_01v8 w=0.65 l=0.15
XP0 Y A VPWR VPB sky130_fd_pr__pfet_01v8_hvt w=1.0 l=0.15
XN1 Y A VGND VNB sky130_fd_pr__nfet_01v8 w=0.65 l=0.15
XP1 Y A VPWR VPB sky130_fd_pr__pfet_01v8_hvt w=1.0 l=0.15
XN2 Y A VGND VNB sky130_fd_pr__nfet_01v8 w=0.65 l=0.15
XP2 Y A VPWR VPB sky130_fd_pr__pfet_01v8_hvt w=1.0 l=0.15
XN3 Y A VGND VNB sky130_fd_pr__nfet_01v8 w=0.65 l=0.15
XP3 Y A VPWR VPB sky130_fd_pr__pfet_01v8_hvt w=1.0 l=0.15
XN4 Y A VGND VNB sky130_fd_pr__nfet_01v8 w=0.65 l=0.15
XP4 Y A VPWR VPB sky130_fd_pr__pfet_01v8_hvt w=1.0 l=0.15
XN5 Y A VGND VNB sky130_fd_pr__nfet_01v8 w=0.65 l=0.15
XP5 Y A VPWR VPB sky130_fd_pr__pfet_01v8_hvt w=1.0 l=0.15
XN6 Y A VGND VNB sky130_fd_pr__nfet_01v8 w=0.65 l=0.15
XP6 Y A VPWR VPB sky130_fd_pr__pfet_01v8_hvt w=1.0 l=0.15
XN7 Y A VGND VNB sky130_fd_pr__nfet_01v8 w=0.65 l=0.15
XP7 Y A VPWR VPB sky130_fd_pr__pfet_01v8_hvt w=1.0 l=0.15
.ends
.subckt inv16 A VGND VNB VPB VPWR Y
XN0 Y A VGND VNB sky130_fd_pr__nfet_01v8 w=0.65 l=0.15
XP0 Y A VPWR VPB sky130_fd_pr__pfet_01v8_hvt w=1.0 l=0.15
XN1 Y A VGND VNB sky130_fd_pr__nfet_01v8 w=0.65 l=0.15
XP1 Y A VPWR VPB sky130_fd_pr__pfet_01v8_hvt w=1.0 l=0.15
XN2 Y A VGND VNB sky130_fd_pr__nfet_01v8 w=0.65 l=0.15
XP2 Y A VPWR VPB sky130_fd_pr__pfet_01v8_hvt w=1.0 l=0.15
XN3 Y A VGND VNB sky130_fd_pr__nfet_01v8 w=0.65 l=0.15
XP3 Y A VPWR VPB sky130_fd_pr__pfet_01v8_hvt w=1.0 l=0.15
XN4 Y A VGND VNB sky130_fd_pr__nfet_01v8 w=0.65 l=0.15
XP4 Y A VPWR VPB sky130_fd_pr__pfet_01v8_hvt w=1.0 l=0.15
XN5 Y A VGND VNB sky130_fd_pr__nfet_01v8 w=0.65 l=0.15
XP5 Y A VPWR VPB sky130_fd_pr__pfet_01v8_hvt w=1.0 l=0.15
XN6 Y A VGND VNB sky130_fd_pr__nfet_01v8 w=0.65 l=0.15
XP6 Y A VPWR VPB sky130_fd_pr__pfet_01v8_hvt w=1.0 l=0.15
XN7 Y A VGND VNB sky130_fd_pr__nfet_01v8 w=0.65 l=0.15
XP7 Y A VPWR VPB sky130_fd_pr__pfet_01v8_hvt w=1.0 l=0.15
XN8 Y A VGND VNB sky130_fd_pr__nfet_01v8 w=0.65 l=0.15
XP8 Y A VPWR VPB sky130_fd_pr__pfet_01v8_hvt w=1.0 l=0.15
XN9 Y A VGND VNB sky130_fd_pr__nfet_01v8 w=0.65 l=0.15
XP9 Y A VPWR VPB sky130_fd_pr__pfet_01v8_hvt w=1.0 l=0.15
XN10 Y A VGND VNB sky130_fd_pr__nfet_01v8 w=0.65 l=0.15
XP10 Y A VPWR VPB sky130_fd_pr__pfet_01v8_hvt w=1.0 l=0.15
XN11 Y A VGND VNB sky130_fd_pr__nfet_01v8 w=0.65 l=0.15
XP11 Y A VPWR VPB sky130_fd_pr__pfet_01v8_hvt w=1.0 l=0.15
XN12 Y A VGND VNB sky130_fd_pr__nfet_01v8 w=0.65 l=0.15
XP12 Y A VPWR VPB sky130_fd_pr__pfet_01v8_hvt w=1.0 l=0.15
XN13 Y A VGND VNB sky130_fd_pr__nfet_01v8 w=0.65 l=0.15
XP13 Y A VPWR VPB sky130_fd_pr__pfet_01v8_hvt w=1.0 l=0.15
XN14 Y A VGND VNB sky130_fd_pr__nfet_01v8 w=0.65 l=0.15
XP14 Y A VPWR VPB sky130_fd_pr__pfet_01v8_hvt w=1.0 l=0.15
XN15 Y A VGND VNB sky130_fd_pr__nfet_01v8 w=0.65 l=0.15
XP15 Y A VPWR VPB sky130_fd_pr__pfet_01v8_hvt w=1.0 l=0.15
.ends
VDD vdd 0 1.8
VIN in 0 PULSE(0 1.8 0.3n 20p 20p 7n 14n)
XS0 in 0 0 vdd vdd s0 inv1
XS1 s0 0 0 vdd vdd a inv1
XDRV0 a 0 0 vdd vdd y0_0 inv4
RUP0 y0_0 w0_0 152.0
CA0_0 w0_0 0 2.1175f
RW0_0 w0_0 w0_1 44.64285714285714
CB0_0 w0_1 0 2.1175f
CA0_1 w0_1 0 2.1175f
RW0_1 w0_1 w0_2 44.64285714285714
CB0_1 w0_2 0 2.1175f
CA0_2 w0_2 0 2.1175f
RW0_2 w0_2 w0_3 44.64285714285714
CB0_2 w0_3 0 2.1175f
CA0_3 w0_3 0 2.1175f
RW0_3 w0_3 w0_4 44.64285714285714
CB0_3 w0_4 0 2.1175f
CA0_4 w0_4 0 2.1175f
RW0_4 w0_4 w0_5 44.64285714285714
CB0_4 w0_5 0 2.1175f
CA0_5 w0_5 0 2.1175f
RW0_5 w0_5 w0_6 44.64285714285714
CB0_5 w0_6 0 2.1175f
CA0_6 w0_6 0 2.1175f
RW0_6 w0_6 w0_7 44.64285714285714
CB0_6 w0_7 0 2.1175f
CA0_7 w0_7 0 2.1175f
RW0_7 w0_7 w0_8 44.64285714285714
CB0_7 w0_8 0 2.1175f
CA0_8 w0_8 0 2.1175f
RW0_8 w0_8 w0_9 44.64285714285714
CB0_8 w0_9 0 2.1175f
CA0_9 w0_9 0 2.1175f
RW0_9 w0_9 w0_10 44.64285714285714
CB0_9 w0_10 0 2.1175f
RDN0 w0_10 g0 152.0
XR0 g0 0 0 vdd vdd y1_0 inv4
RUP1 y1_0 w1_0 152.0
CA1_0 w1_0 0 2.1175f
RW1_0 w1_0 w1_1 44.64285714285714
CB1_0 w1_1 0 2.1175f
CA1_1 w1_1 0 2.1175f
RW1_1 w1_1 w1_2 44.64285714285714
CB1_1 w1_2 0 2.1175f
CA1_2 w1_2 0 2.1175f
RW1_2 w1_2 w1_3 44.64285714285714
CB1_2 w1_3 0 2.1175f
CA1_3 w1_3 0 2.1175f
RW1_3 w1_3 w1_4 44.64285714285714
CB1_3 w1_4 0 2.1175f
CA1_4 w1_4 0 2.1175f
RW1_4 w1_4 w1_5 44.64285714285714
CB1_4 w1_5 0 2.1175f
CA1_5 w1_5 0 2.1175f
RW1_5 w1_5 w1_6 44.64285714285714
CB1_5 w1_6 0 2.1175f
CA1_6 w1_6 0 2.1175f
RW1_6 w1_6 w1_7 44.64285714285714
CB1_6 w1_7 0 2.1175f
CA1_7 w1_7 0 2.1175f
RW1_7 w1_7 w1_8 44.64285714285714
CB1_7 w1_8 0 2.1175f
CA1_8 w1_8 0 2.1175f
RW1_8 w1_8 w1_9 44.64285714285714
CB1_8 w1_9 0 2.1175f
CA1_9 w1_9 0 2.1175f
RW1_9 w1_9 w1_10 44.64285714285714
CB1_9 w1_10 0 2.1175f
RDN1 w1_10 g1 152.0
XR1 g1 0 0 vdd vdd y2_0 inv4
RUP2 y2_0 w2_0 152.0
CA2_0 w2_0 0 2.1175f
RW2_0 w2_0 w2_1 44.64285714285714
CB2_0 w2_1 0 2.1175f
CA2_1 w2_1 0 2.1175f
RW2_1 w2_1 w2_2 44.64285714285714
CB2_1 w2_2 0 2.1175f
CA2_2 w2_2 0 2.1175f
RW2_2 w2_2 w2_3 44.64285714285714
CB2_2 w2_3 0 2.1175f
CA2_3 w2_3 0 2.1175f
RW2_3 w2_3 w2_4 44.64285714285714
CB2_3 w2_4 0 2.1175f
CA2_4 w2_4 0 2.1175f
RW2_4 w2_4 w2_5 44.64285714285714
CB2_4 w2_5 0 2.1175f
CA2_5 w2_5 0 2.1175f
RW2_5 w2_5 w2_6 44.64285714285714
CB2_5 w2_6 0 2.1175f
CA2_6 w2_6 0 2.1175f
RW2_6 w2_6 w2_7 44.64285714285714
CB2_6 w2_7 0 2.1175f
CA2_7 w2_7 0 2.1175f
RW2_7 w2_7 w2_8 44.64285714285714
CB2_7 w2_8 0 2.1175f
CA2_8 w2_8 0 2.1175f
RW2_8 w2_8 w2_9 44.64285714285714
CB2_8 w2_9 0 2.1175f
CA2_9 w2_9 0 2.1175f
RW2_9 w2_9 w2_10 44.64285714285714
CB2_9 w2_10 0 2.1175f
RDN2 w2_10 g2 152.0
XR2 g2 0 0 vdd vdd y3_0 inv4
RUP3 y3_0 w3_0 152.0
CA3_0 w3_0 0 2.1175f
RW3_0 w3_0 w3_1 44.64285714285714
CB3_0 w3_1 0 2.1175f
CA3_1 w3_1 0 2.1175f
RW3_1 w3_1 w3_2 44.64285714285714
CB3_1 w3_2 0 2.1175f
CA3_2 w3_2 0 2.1175f
RW3_2 w3_2 w3_3 44.64285714285714
CB3_2 w3_3 0 2.1175f
CA3_3 w3_3 0 2.1175f
RW3_3 w3_3 w3_4 44.64285714285714
CB3_3 w3_4 0 2.1175f
CA3_4 w3_4 0 2.1175f
RW3_4 w3_4 w3_5 44.64285714285714
CB3_4 w3_5 0 2.1175f
CA3_5 w3_5 0 2.1175f
RW3_5 w3_5 w3_6 44.64285714285714
CB3_5 w3_6 0 2.1175f
CA3_6 w3_6 0 2.1175f
RW3_6 w3_6 w3_7 44.64285714285714
CB3_6 w3_7 0 2.1175f
CA3_7 w3_7 0 2.1175f
RW3_7 w3_7 w3_8 44.64285714285714
CB3_7 w3_8 0 2.1175f
CA3_8 w3_8 0 2.1175f
RW3_8 w3_8 w3_9 44.64285714285714
CB3_8 w3_9 0 2.1175f
CA3_9 w3_9 0 2.1175f
RW3_9 w3_9 w3_10 44.64285714285714
CB3_9 w3_10 0 2.1175f
RDN3 w3_10 g3 152.0
XR3 g3 0 0 vdd vdd y4_0 inv4
RUP4 y4_0 w4_0 152.0
CA4_0 w4_0 0 2.1175f
RW4_0 w4_0 w4_1 44.64285714285714
CB4_0 w4_1 0 2.1175f
CA4_1 w4_1 0 2.1175f
RW4_1 w4_1 w4_2 44.64285714285714
CB4_1 w4_2 0 2.1175f
CA4_2 w4_2 0 2.1175f
RW4_2 w4_2 w4_3 44.64285714285714
CB4_2 w4_3 0 2.1175f
CA4_3 w4_3 0 2.1175f
RW4_3 w4_3 w4_4 44.64285714285714
CB4_3 w4_4 0 2.1175f
CA4_4 w4_4 0 2.1175f
RW4_4 w4_4 w4_5 44.64285714285714
CB4_4 w4_5 0 2.1175f
CA4_5 w4_5 0 2.1175f
RW4_5 w4_5 w4_6 44.64285714285714
CB4_5 w4_6 0 2.1175f
CA4_6 w4_6 0 2.1175f
RW4_6 w4_6 w4_7 44.64285714285714
CB4_6 w4_7 0 2.1175f
CA4_7 w4_7 0 2.1175f
RW4_7 w4_7 w4_8 44.64285714285714
CB4_7 w4_8 0 2.1175f
CA4_8 w4_8 0 2.1175f
RW4_8 w4_8 w4_9 44.64285714285714
CB4_8 w4_9 0 2.1175f
CA4_9 w4_9 0 2.1175f
RW4_9 w4_9 w4_10 44.64285714285714
CB4_9 w4_10 0 2.1175f
RDN4 w4_10 g4 152.0
XR4 g4 0 0 vdd vdd y5_0 inv4
RUP5 y5_0 w5_0 152.0
CA5_0 w5_0 0 2.1175f
RW5_0 w5_0 w5_1 44.64285714285714
CB5_0 w5_1 0 2.1175f
CA5_1 w5_1 0 2.1175f
RW5_1 w5_1 w5_2 44.64285714285714
CB5_1 w5_2 0 2.1175f
CA5_2 w5_2 0 2.1175f
RW5_2 w5_2 w5_3 44.64285714285714
CB5_2 w5_3 0 2.1175f
CA5_3 w5_3 0 2.1175f
RW5_3 w5_3 w5_4 44.64285714285714
CB5_3 w5_4 0 2.1175f
CA5_4 w5_4 0 2.1175f
RW5_4 w5_4 w5_5 44.64285714285714
CB5_4 w5_5 0 2.1175f
CA5_5 w5_5 0 2.1175f
RW5_5 w5_5 w5_6 44.64285714285714
CB5_5 w5_6 0 2.1175f
CA5_6 w5_6 0 2.1175f
RW5_6 w5_6 w5_7 44.64285714285714
CB5_6 w5_7 0 2.1175f
CA5_7 w5_7 0 2.1175f
RW5_7 w5_7 w5_8 44.64285714285714
CB5_7 w5_8 0 2.1175f
CA5_8 w5_8 0 2.1175f
RW5_8 w5_8 w5_9 44.64285714285714
CB5_8 w5_9 0 2.1175f
CA5_9 w5_9 0 2.1175f
RW5_9 w5_9 w5_10 44.64285714285714
CB5_9 w5_10 0 2.1175f
RDN5 w5_10 g5 152.0
XLD g5 0 0 vdd vdd z inv1
CZ z 0 9.208f

.control
set wr_vecnames
set wr_singlescale
set numdgt=10
tran 0.5p 16n 0 0.5p
wrdata tran.dat v(a) v(g5)
quit
.endc
.end
