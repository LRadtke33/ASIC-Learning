* delay physics
.lib "../../../../common/models/sky130_course.lib.spice" tt
.temp 25
.options reltol=1e-5 abstol=1e-14 vntol=1e-8
.subckt inv1 A VGND VNB VPB VPWR Y
XN0 Y A VGND VNB sky130_fd_pr__nfet_01v8 w=0.65 l=0.15
XP0 Y A VPWR VPB sky130_fd_pr__pfet_01v8_hvt w=1.0 l=0.15
.ends
.subckt inv2 A VGND VNB VPB VPWR Y
XN0 Y A VGND VNB sky130_fd_pr__nfet_01v8 w=0.65 l=0.15
XP0 Y A VPWR VPB sky130_fd_pr__pfet_01v8_hvt w=1.0 l=0.15
XN1 Y A VGND VNB sky130_fd_pr__nfet_01v8 w=0.65 l=0.15
XP1 Y A VPWR VPB sky130_fd_pr__pfet_01v8_hvt w=1.0 l=0.15
.ends
.subckt inv4 A VGND VNB VPB VPWR Y
XN0 Y A VGND VNB sky130_fd_pr__nfet_01v8 w=0.65 l=0.15
XP0 Y A VPWR VPB sky130_fd_pr__pfet_01v8_hvt w=1.0 l=0.15
XN1 Y A VGND VNB sky130_fd_pr__nfet_01v8 w=0.65 l=0.15
XP1 Y A VPWR VPB sky130_fd_pr__pfet_01v8_hvt w=1.0 l=0.15
XN2 Y A VGND VNB sky130_fd_pr__nfet_01v8 w=0.65 l=0.15
XP2 Y A VPWR VPB sky130_fd_pr__pfet_01v8_hvt w=1.0 l=0.15
XN3 Y A VGND VNB sky130_fd_pr__nfet_01v8 w=0.65 l=0.15
XP3 Y A VPWR VPB sky130_fd_pr__pfet_01v8_hvt w=1.0 l=0.15
.ends
.subckt inv8 A VGND VNB VPB VPWR Y
XN0 Y A VGND VNB sky130_fd_pr__nfet_01v8 w=0.65 l=0.15
XP0 Y A VPWR VPB sky130_fd_pr__pfet_01v8_hvt w=1.0 l=0.15
XN1 Y A VGND VNB sky130_fd_pr__nfet_01v8 w=0.65 l=0.15
XP1 Y A VPWR VPB sky130_fd_pr__pfet_01v8_hvt w=1.0 l=0.15
XN2 Y A VGND VNB sky130_fd_pr__nfet_01v8 w=0.65 l=0.15
XP2 Y A VPWR VPB sky130_fd_pr__pfet_01v8_hvt w=1.0 l=0.15
XN3 Y A VGND VNB sky130_fd_pr__nfet_01v8 w=0.65 l=0.15
XP3 Y A VPWR VPB sky130_fd_pr__pfet_01v8_hvt w=1.0 l=0.15
XN4 Y A VGND VNB sky130_fd_pr__nfet_01v8 w=0.65 l=0.15
XP4 Y A VPWR VPB sky130_fd_pr__pfet_01v8_hvt w=1.0 l=0.15
XN5 Y A VGND VNB sky130_fd_pr__nfet_01v8 w=0.65 l=0.15
XP5 Y A VPWR VPB sky130_fd_pr__pfet_01v8_hvt w=1.0 l=0.15
XN6 Y A VGND VNB sky130_fd_pr__nfet_01v8 w=0.65 l=0.15
XP6 Y A VPWR VPB sky130_fd_pr__pfet_01v8_hvt w=1.0 l=0.15
XN7 Y A VGND VNB sky130_fd_pr__nfet_01v8 w=0.65 l=0.15
XP7 Y A VPWR VPB sky130_fd_pr__pfet_01v8_hvt w=1.0 l=0.15
.ends
.subckt inv16 A VGND VNB VPB VPWR Y
XN0 Y A VGND VNB sky130_fd_pr__nfet_01v8 w=0.65 l=0.15
XP0 Y A VPWR VPB sky130_fd_pr__pfet_01v8_hvt w=1.0 l=0.15
XN1 Y A VGND VNB sky130_fd_pr__nfet_01v8 w=0.65 l=0.15
XP1 Y A VPWR VPB sky130_fd_pr__pfet_01v8_hvt w=1.0 l=0.15
XN2 Y A VGND VNB sky130_fd_pr__nfet_01v8 w=0.65 l=0.15
XP2 Y A VPWR VPB sky130_fd_pr__pfet_01v8_hvt w=1.0 l=0.15
XN3 Y A VGND VNB sky130_fd_pr__nfet_01v8 w=0.65 l=0.15
XP3 Y A VPWR VPB sky130_fd_pr__pfet_01v8_hvt w=1.0 l=0.15
XN4 Y A VGND VNB sky130_fd_pr__nfet_01v8 w=0.65 l=0.15
XP4 Y A VPWR VPB sky130_fd_pr__pfet_01v8_hvt w=1.0 l=0.15
XN5 Y A VGND VNB sky130_fd_pr__nfet_01v8 w=0.65 l=0.15
XP5 Y A VPWR VPB sky130_fd_pr__pfet_01v8_hvt w=1.0 l=0.15
XN6 Y A VGND VNB sky130_fd_pr__nfet_01v8 w=0.65 l=0.15
XP6 Y A VPWR VPB sky130_fd_pr__pfet_01v8_hvt w=1.0 l=0.15
XN7 Y A VGND VNB sky130_fd_pr__nfet_01v8 w=0.65 l=0.15
XP7 Y A VPWR VPB sky130_fd_pr__pfet_01v8_hvt w=1.0 l=0.15
XN8 Y A VGND VNB sky130_fd_pr__nfet_01v8 w=0.65 l=0.15
XP8 Y A VPWR VPB sky130_fd_pr__pfet_01v8_hvt w=1.0 l=0.15
XN9 Y A VGND VNB sky130_fd_pr__nfet_01v8 w=0.65 l=0.15
XP9 Y A VPWR VPB sky130_fd_pr__pfet_01v8_hvt w=1.0 l=0.15
XN10 Y A VGND VNB sky130_fd_pr__nfet_01v8 w=0.65 l=0.15
XP10 Y A VPWR VPB sky130_fd_pr__pfet_01v8_hvt w=1.0 l=0.15
XN11 Y A VGND VNB sky130_fd_pr__nfet_01v8 w=0.65 l=0.15
XP11 Y A VPWR VPB sky130_fd_pr__pfet_01v8_hvt w=1.0 l=0.15
XN12 Y A VGND VNB sky130_fd_pr__nfet_01v8 w=0.65 l=0.15
XP12 Y A VPWR VPB sky130_fd_pr__pfet_01v8_hvt w=1.0 l=0.15
XN13 Y A VGND VNB sky130_fd_pr__nfet_01v8 w=0.65 l=0.15
XP13 Y A VPWR VPB sky130_fd_pr__pfet_01v8_hvt w=1.0 l=0.15
XN14 Y A VGND VNB sky130_fd_pr__nfet_01v8 w=0.65 l=0.15
XP14 Y A VPWR VPB sky130_fd_pr__pfet_01v8_hvt w=1.0 l=0.15
XN15 Y A VGND VNB sky130_fd_pr__nfet_01v8 w=0.65 l=0.15
XP15 Y A VPWR VPB sky130_fd_pr__pfet_01v8_hvt w=1.0 l=0.15
.ends
VDD vdd 0 1.8
VIN in 0 PULSE(0 1.8 0.3n 20p 20p 7n 14n)
XS0 in 0 0 vdd vdd s0 inv1
XS1 s0 0 0 vdd vdd a inv1
XDRV0 a 0 0 vdd vdd y0_0 inv4
RUP0 y0_0 w0_0 152.0
CA0_0 w0_0 0 2.1175f
RW0_0 w0_0 w0_1 44.64285714285714
CB0_0 w0_1 0 2.1175f
CA0_1 w0_1 0 2.1175f
RW0_1 w0_1 w0_2 44.64285714285714
CB0_1 w0_2 0 2.1175f
CA0_2 w0_2 0 2.1175f
RW0_2 w0_2 w0_3 44.64285714285714
CB0_2 w0_3 0 2.1175f
CA0_3 w0_3 0 2.1175f
RW0_3 w0_3 w0_4 44.64285714285714
CB0_3 w0_4 0 2.1175f
CA0_4 w0_4 0 2.1175f
RW0_4 w0_4 w0_5 44.64285714285714
CB0_4 w0_5 0 2.1175f
CA0_5 w0_5 0 2.1175f
RW0_5 w0_5 w0_6 44.64285714285714
CB0_5 w0_6 0 2.1175f
CA0_6 w0_6 0 2.1175f
RW0_6 w0_6 w0_7 44.64285714285714
CB0_6 w0_7 0 2.1175f
CA0_7 w0_7 0 2.1175f
RW0_7 w0_7 w0_8 44.64285714285714
CB0_7 w0_8 0 2.1175f
CA0_8 w0_8 0 2.1175f
RW0_8 w0_8 w0_9 44.64285714285714
CB0_8 w0_9 0 2.1175f
CA0_9 w0_9 0 2.1175f
RW0_9 w0_9 w0_10 44.64285714285714
CB0_9 w0_10 0 2.1175f
CA0_10 w0_10 0 2.1175f
RW0_10 w0_10 w0_11 44.64285714285714
CB0_10 w0_11 0 2.1175f
CA0_11 w0_11 0 2.1175f
RW0_11 w0_11 w0_12 44.64285714285714
CB0_11 w0_12 0 2.1175f
CA0_12 w0_12 0 2.1175f
RW0_12 w0_12 w0_13 44.64285714285714
CB0_12 w0_13 0 2.1175f
CA0_13 w0_13 0 2.1175f
RW0_13 w0_13 w0_14 44.64285714285714
CB0_13 w0_14 0 2.1175f
CA0_14 w0_14 0 2.1175f
RW0_14 w0_14 w0_15 44.64285714285714
CB0_14 w0_15 0 2.1175f
CA0_15 w0_15 0 2.1175f
RW0_15 w0_15 w0_16 44.64285714285714
CB0_15 w0_16 0 2.1175f
CA0_16 w0_16 0 2.1175f
RW0_16 w0_16 w0_17 44.64285714285714
CB0_16 w0_17 0 2.1175f
CA0_17 w0_17 0 2.1175f
RW0_17 w0_17 w0_18 44.64285714285714
CB0_17 w0_18 0 2.1175f
CA0_18 w0_18 0 2.1175f
RW0_18 w0_18 w0_19 44.64285714285714
CB0_18 w0_19 0 2.1175f
CA0_19 w0_19 0 2.1175f
RW0_19 w0_19 w0_20 44.64285714285714
CB0_19 w0_20 0 2.1175f
CA0_20 w0_20 0 2.1175f
RW0_20 w0_20 w0_21 44.64285714285714
CB0_20 w0_21 0 2.1175f
CA0_21 w0_21 0 2.1175f
RW0_21 w0_21 w0_22 44.64285714285714
CB0_21 w0_22 0 2.1175f
CA0_22 w0_22 0 2.1175f
RW0_22 w0_22 w0_23 44.64285714285714
CB0_22 w0_23 0 2.1175f
CA0_23 w0_23 0 2.1175f
RW0_23 w0_23 w0_24 44.64285714285714
CB0_23 w0_24 0 2.1175f
CA0_24 w0_24 0 2.1175f
RW0_24 w0_24 w0_25 44.64285714285714
CB0_24 w0_25 0 2.1175f
CA0_25 w0_25 0 2.1175f
RW0_25 w0_25 w0_26 44.64285714285714
CB0_25 w0_26 0 2.1175f
CA0_26 w0_26 0 2.1175f
RW0_26 w0_26 w0_27 44.64285714285714
CB0_26 w0_27 0 2.1175f
CA0_27 w0_27 0 2.1175f
RW0_27 w0_27 w0_28 44.64285714285714
CB0_27 w0_28 0 2.1175f
CA0_28 w0_28 0 2.1175f
RW0_28 w0_28 w0_29 44.64285714285714
CB0_28 w0_29 0 2.1175f
CA0_29 w0_29 0 2.1175f
RW0_29 w0_29 w0_30 44.64285714285714
CB0_29 w0_30 0 2.1175f
CA0_30 w0_30 0 2.1175f
RW0_30 w0_30 w0_31 44.64285714285714
CB0_30 w0_31 0 2.1175f
CA0_31 w0_31 0 2.1175f
RW0_31 w0_31 w0_32 44.64285714285714
CB0_31 w0_32 0 2.1175f
CA0_32 w0_32 0 2.1175f
RW0_32 w0_32 w0_33 44.64285714285714
CB0_32 w0_33 0 2.1175f
CA0_33 w0_33 0 2.1175f
RW0_33 w0_33 w0_34 44.64285714285714
CB0_33 w0_34 0 2.1175f
CA0_34 w0_34 0 2.1175f
RW0_34 w0_34 w0_35 44.64285714285714
CB0_34 w0_35 0 2.1175f
CA0_35 w0_35 0 2.1175f
RW0_35 w0_35 w0_36 44.64285714285714
CB0_35 w0_36 0 2.1175f
CA0_36 w0_36 0 2.1175f
RW0_36 w0_36 w0_37 44.64285714285714
CB0_36 w0_37 0 2.1175f
CA0_37 w0_37 0 2.1175f
RW0_37 w0_37 w0_38 44.64285714285714
CB0_37 w0_38 0 2.1175f
CA0_38 w0_38 0 2.1175f
RW0_38 w0_38 w0_39 44.64285714285714
CB0_38 w0_39 0 2.1175f
CA0_39 w0_39 0 2.1175f
RW0_39 w0_39 w0_40 44.64285714285714
CB0_39 w0_40 0 2.1175f
CA0_40 w0_40 0 2.1175f
RW0_40 w0_40 w0_41 44.64285714285714
CB0_40 w0_41 0 2.1175f
CA0_41 w0_41 0 2.1175f
RW0_41 w0_41 w0_42 44.64285714285714
CB0_41 w0_42 0 2.1175f
CA0_42 w0_42 0 2.1175f
RW0_42 w0_42 w0_43 44.64285714285714
CB0_42 w0_43 0 2.1175f
CA0_43 w0_43 0 2.1175f
RW0_43 w0_43 w0_44 44.64285714285714
CB0_43 w0_44 0 2.1175f
CA0_44 w0_44 0 2.1175f
RW0_44 w0_44 w0_45 44.64285714285714
CB0_44 w0_45 0 2.1175f
CA0_45 w0_45 0 2.1175f
RW0_45 w0_45 w0_46 44.64285714285714
CB0_45 w0_46 0 2.1175f
CA0_46 w0_46 0 2.1175f
RW0_46 w0_46 w0_47 44.64285714285714
CB0_46 w0_47 0 2.1175f
CA0_47 w0_47 0 2.1175f
RW0_47 w0_47 w0_48 44.64285714285714
CB0_47 w0_48 0 2.1175f
CA0_48 w0_48 0 2.1175f
RW0_48 w0_48 w0_49 44.64285714285714
CB0_48 w0_49 0 2.1175f
CA0_49 w0_49 0 2.1175f
RW0_49 w0_49 w0_50 44.64285714285714
CB0_49 w0_50 0 2.1175f
CA0_50 w0_50 0 2.1175f
RW0_50 w0_50 w0_51 44.64285714285714
CB0_50 w0_51 0 2.1175f
CA0_51 w0_51 0 2.1175f
RW0_51 w0_51 w0_52 44.64285714285714
CB0_51 w0_52 0 2.1175f
CA0_52 w0_52 0 2.1175f
RW0_52 w0_52 w0_53 44.64285714285714
CB0_52 w0_53 0 2.1175f
CA0_53 w0_53 0 2.1175f
RW0_53 w0_53 w0_54 44.64285714285714
CB0_53 w0_54 0 2.1175f
CA0_54 w0_54 0 2.1175f
RW0_54 w0_54 w0_55 44.64285714285714
CB0_54 w0_55 0 2.1175f
CA0_55 w0_55 0 2.1175f
RW0_55 w0_55 w0_56 44.64285714285714
CB0_55 w0_56 0 2.1175f
CA0_56 w0_56 0 2.1175f
RW0_56 w0_56 w0_57 44.64285714285714
CB0_56 w0_57 0 2.1175f
CA0_57 w0_57 0 2.1175f
RW0_57 w0_57 w0_58 44.64285714285714
CB0_57 w0_58 0 2.1175f
CA0_58 w0_58 0 2.1175f
RW0_58 w0_58 w0_59 44.64285714285714
CB0_58 w0_59 0 2.1175f
CA0_59 w0_59 0 2.1175f
RW0_59 w0_59 w0_60 44.64285714285714
CB0_59 w0_60 0 2.1175f
RDN0 w0_60 g0 152.0
XLD g0 0 0 vdd vdd z inv1
CZ z 0 9.208f

.control
set wr_vecnames
set wr_singlescale
set numdgt=10
tran 0.5p 16n 0 0.5p
wrdata tran.dat v(a) v(g0)
quit
.endc
.end
